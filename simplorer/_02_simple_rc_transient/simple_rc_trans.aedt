# Ansys Electronics Desktop project, version 2022.2

design Simplorer1 (Twin Builder)
components:
  R1 = R(R=1kOhm)
  C1 = C(C=100nF)
  vpulse1 = vpulse(v2=1 td=100u tr=10n tf=10n)
nets:
  0: vpulse1.1, C1.1
  in: vpulse1.0, R1.1
  out: R1.0, C1.0
setups:
  TR: TransientData(800us, 1us, 1us, false, "")
reports:
  XY Plot 1: C1.V vs Time on TR : TR; markers m1 at 199500ns, m2 at 100000ns
