# Ansys Electronics Desktop project, version 2022.2

design Simplorer1 (Twin Builder)
components:
  R1 = R(R=1kOhm)
  C1 = C(C=100nF)
  e_ac1 = e_ac()
nets:
  0: e_ac1.0, C1.1
  in: R1.1, e_ac1.1
  Out: R1.0, C1.0
setups:
  AC1: LinearFrequencyData(2, 10Hz, 100kHz, 10) EnableContSolve
reports:
  XY Plot 1: dB(C1.V), ang_deg(C1.V) vs Freq on AC1 : AC1; markers m1 at 1.5848932e-06GHz, m2 at 1.5848932kHz
