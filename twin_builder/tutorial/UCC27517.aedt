# Ansys Electronics Desktop project, version 2022.2

design Example (Twin Builder)
components:
  Supply = E(PERIO=0 EMF=5V)
  Input = E(Type=EPULSE AMPL=5V FREQ=1MHz PERIO=0 TPERIO=Tend+1)
  Rpd = R(R=1k)
  UCC27517_1 = UCC27517()
  MOSFET1 = IRFB4310(ParamVersion=210725 TYPE_FWD=2)
  Rgate = R(R=2ohm)
  Rload = R(R=500mOhm)
  Supply1 = E(PERIO=0 EMF=2V PARTDERIV=0 TPERIO=Tend+1 V=0)
nets:
  0: Supply.0, Input.0, UCC27517_1.3, UCC27517_1.4, Rpd.1, MOSFET1.1, MOSFET1.2, Supply1.0
  drv_out: UCC27517_1.1, Rpd.0, Rgate.0
  mosfet_drain: MOSFET1.3, Rload.1
  mosfet_gate: MOSFET1.0, Rgate.1
  net_51: Input.1, UCC27517_1.2
  net_54: Supply.1, UCC27517_1.0
  net_7: Rload.0, Supply1.1
setups:
  TR: TransientData(2.5us, 1ns, 1ns, false, "")
reports:
  mosfet_drain Probe 3: mosfet_drain.V, mosfet_gate.V vs Time on TR : TR
  drv_out Probe 4: drv_out.V vs Time on TR : TR
