# Ansys Electronics Desktop project, version 2022.2

design openrex_edb_v3_TDR1 (Circuit)
options: SParamCircuitDef IntegrationMethod=FFT
components:
  U100 = openrex_edb_v3(Net(DRAM_D0_AD2_PBGA624_U1_ref)=0 Net(DRAM_D0_E3_96_FPGA_DD3_14MMX10MM-SMALL_SIZE_U2_ref)=0 Net(DRAM_D1_AE2_PBGA624_U1_ref)=0 Net(DRAM_D1_H3_96_FPGA_DD3_14MMX10MM-SMALL_SIZE_U2_ref)=0 Net(DRAM_D2_AC4_PBGA624_U1_ref)=0 Net(DRAM_D2_H7_96_FPGA_DD3_14MMX10MM-SMALL_SIZE_U2_ref)=0 Net(DRAM_D3_AA5_PBGA624_U1_ref)=0 Net(DRAM_D3_F8_96_FPGA_DD3_14MMX10MM-SMALL_SIZE_U2_ref)=0 Net(DRAM_D4_AC1_PBGA624_U1_ref)=0 Net(DRAM_D4_F2_96_FPGA_DD3_14MMX10MM-SMALL_SIZE_U2_ref)=0 Net(DRAM_D5_AD1_PBGA624_U1_ref)=0 Net(DRAM_D5_G2_96_FPGA_DD3_14MMX10MM-SMALL_SIZE_U2_ref)=0 Net(DRAM_D6_AB4_PBGA624_U1_ref)=0 Net(DRAM_D6_F7_96_FPGA_DD3_14MMX10MM-SMALL_SIZE_U2_ref)=0 Net(DRAM_D7_AE4_PBGA624_U1_ref)=0 Net(DRAM_D7_H8_96_FPGA_DD3_14MMX10MM-SMALL_SIZE_U2_ref)=0 Net(DRAM_DQS0_N_AD3_PBGA624_U1_ref)=0 Net(DRAM_DQS0_N_G3_96_FPGA_DD3_14MMX10MM-SMALL_SIZE_U2_ref)=0 Net(DRAM_DQS0_P_AE3_PBGA624_U1_ref)=0 Net(DRAM_DQS0_P_F3_96_FPGA_DD3_14MMX10MM-SMALL_SIZE_U2_ref)=0)
  ADRAM_D0_AD2_PBGA624_U1 = TDR_Single_Ended(Rise_time=35ps Pulse_width=10us Pulse_repetition=20us Z0=50ohm Time_delay=0.5ns)
  ADRAM_D1_AE2_PBGA624_U1 = TDR_Single_Ended(Rise_time=35ps Pulse_width=10us Pulse_repetition=20us Z0=50ohm Time_delay=0.5ns)
  ADRAM_D2_AC4_PBGA624_U1 = TDR_Single_Ended(Rise_time=35ps Pulse_width=10us Pulse_repetition=20us Z0=50ohm Time_delay=0.5ns)
  ADRAM_D3_AA5_PBGA624_U1 = TDR_Single_Ended(Rise_time=35ps Pulse_width=10us Pulse_repetition=20us Z0=50ohm Time_delay=0.5ns)
  ADRAM_D4_AC1_PBGA624_U1 = TDR_Single_Ended(Rise_time=35ps Pulse_width=10us Pulse_repetition=20us Z0=50ohm Time_delay=0.5ns)
  ADRAM_D5_AD1_PBGA624_U1 = TDR_Single_Ended(Rise_time=35ps Pulse_width=10us Pulse_repetition=20us Z0=50ohm Time_delay=0.5ns)
  ADRAM_D6_AB4_PBGA624_U1 = TDR_Single_Ended(Rise_time=35ps Pulse_width=10us Pulse_repetition=20us Z0=50ohm Time_delay=0.5ns)
  ADRAM_D7_AE4_PBGA624_U1 = TDR_Single_Ended(Rise_time=35ps Pulse_width=10us Pulse_repetition=20us Z0=50ohm Time_delay=0.5ns)
  ADRAM_DQS0_P_AE3_PBGA624_U1 = TDR_Differential_Ended(Rise_time=35ps Pulse_width=10us Pulse_repetition=20us Z0=100ohm Time_delay=0.5ns)
  R1 = RES_(R=50ohm)
  R2 = RES_(R=50ohm)
  R3 = RES_(R=50ohm)
  R4 = RES_(R=50ohm)
  R5 = RES_(R=50ohm)
  R6 = RES_(R=50ohm)
  R7 = RES_(R=50ohm)
  R8 = RES_(R=50ohm)
  R9 = RES_(R=100ohm)
nets:
  0: R4.1, R1.1, R3.1, R2.1, R7.1, R6.1, R5.1, R8.1
  DRAM_D0_AD2_PBGA624_U1: U100.DRAM_D0_AD2_PBGA624_U1, ADRAM_D0_AD2_PBGA624_U1.0
  DRAM_D0_E3_96_FPGA_DD3_14MMX10MM-SMALL_SIZE_U2: U100.DRAM_D0_E3_96_FPGA_DD3_14MMX10MM-SMALL_SIZE_U2, R1.0
  DRAM_D1_AE2_PBGA624_U1: U100.DRAM_D1_AE2_PBGA624_U1, ADRAM_D1_AE2_PBGA624_U1.0
  DRAM_D1_H3_96_FPGA_DD3_14MMX10MM-SMALL_SIZE_U2: U100.DRAM_D1_H3_96_FPGA_DD3_14MMX10MM-SMALL_SIZE_U2, R2.0
  DRAM_D2_AC4_PBGA624_U1: U100.DRAM_D2_AC4_PBGA624_U1, ADRAM_D2_AC4_PBGA624_U1.0
  DRAM_D2_H7_96_FPGA_DD3_14MMX10MM-SMALL_SIZE_U2: U100.DRAM_D2_H7_96_FPGA_DD3_14MMX10MM-SMALL_SIZE_U2, R3.0
  DRAM_D3_AA5_PBGA624_U1: U100.DRAM_D3_AA5_PBGA624_U1, ADRAM_D3_AA5_PBGA624_U1.0
  DRAM_D3_F8_96_FPGA_DD3_14MMX10MM-SMALL_SIZE_U2: U100.DRAM_D3_F8_96_FPGA_DD3_14MMX10MM-SMALL_SIZE_U2, R4.0
  DRAM_D4_AC1_PBGA624_U1: U100.DRAM_D4_AC1_PBGA624_U1, ADRAM_D4_AC1_PBGA624_U1.0
  DRAM_D4_F2_96_FPGA_DD3_14MMX10MM-SMALL_SIZE_U2: U100.DRAM_D4_F2_96_FPGA_DD3_14MMX10MM-SMALL_SIZE_U2, R5.0
  DRAM_D5_AD1_PBGA624_U1: U100.DRAM_D5_AD1_PBGA624_U1, ADRAM_D5_AD1_PBGA624_U1.0
  DRAM_D5_G2_96_FPGA_DD3_14MMX10MM-SMALL_SIZE_U2: U100.DRAM_D5_G2_96_FPGA_DD3_14MMX10MM-SMALL_SIZE_U2, R6.0
  DRAM_D6_AB4_PBGA624_U1: U100.DRAM_D6_AB4_PBGA624_U1, ADRAM_D6_AB4_PBGA624_U1.0
  DRAM_D6_F7_96_FPGA_DD3_14MMX10MM-SMALL_SIZE_U2: U100.DRAM_D6_F7_96_FPGA_DD3_14MMX10MM-SMALL_SIZE_U2, R7.0
  DRAM_D7_AE4_PBGA624_U1: U100.DRAM_D7_AE4_PBGA624_U1, ADRAM_D7_AE4_PBGA624_U1.0
  DRAM_D7_H8_96_FPGA_DD3_14MMX10MM-SMALL_SIZE_U2: U100.DRAM_D7_H8_96_FPGA_DD3_14MMX10MM-SMALL_SIZE_U2, R8.0
  DRAM_DQS0_N_AD3_PBGA624_U1: U100.DRAM_DQS0_N_AD3_PBGA624_U1, ADRAM_DQS0_P_AE3_PBGA624_U1.1
  DRAM_DQS0_N_G3_96_FPGA_DD3_14MMX10MM-SMALL_SIZE_U2: U100.DRAM_DQS0_N_G3_96_FPGA_DD3_14MMX10MM-SMALL_SIZE_U2, R9.0
  DRAM_DQS0_P_AE3_PBGA624_U1: U100.DRAM_DQS0_P_AE3_PBGA624_U1, ADRAM_DQS0_P_AE3_PBGA624_U1.0
  DRAM_DQS0_P_F3_96_FPGA_DD3_14MMX10MM-SMALL_SIZE_U2: U100.DRAM_DQS0_P_F3_96_FPGA_DD3_14MMX10MM-SMALL_SIZE_U2, R9.1
setups:
  Transient1: TransientData(1e-10, 5e-09) TransientNoiseData(false, "", "", 0, 1, 0, false, 1) TransientOtherData(default)
reports:
  Voltage Waveform at Probe/Termination Nodes: V(DRAM_D0_AD2_PBGA624_U1), V(DRAM_D1_AE2_PBGA624_U1), V(DRAM_D2_AC4_PBGA624_U1), V(DRAM_D3_AA5_PBGA624_U1), V(DRAM_D4_AC1_PBGA624_U1), V(DRAM_D5_AD1_PBGA624_U1), V(DRAM_D6_AB4_PBGA624_U1), V(DRAM_D7_AE4_PBGA624_U1), V(DRAM_DQS0_P_AE3_PBGA624_U1), V(DRAM_DQS0_N_AD3_PBGA624_U1), V(DRAM_D0_E3_96_FPGA_DD3_14MMX10MM-SMALL_SIZE_U2), V(DRAM_D1_H3_96_FPGA_DD3_14MMX10MM-SMALL_SIZE_U2), V(DRAM_D2_H7_96_FPGA_DD3_14MMX10MM-SMALL_SIZE_U2), V(DRAM_D3_F8_96_FPGA_DD3_14MMX10MM-SMALL_SIZE_U2), V(DRAM_D4_F2_96_FPGA_DD3_14MMX10MM-SMALL_SIZE_U2), V(DRAM_D5_G2_96_FPGA_DD3_14MMX10MM-SMALL_SIZE_U2), V(DRAM_D6_F7_96_FPGA_DD3_14MMX10MM-SMALL_SIZE_U2), V(DRAM_D7_H8_96_FPGA_DD3_14MMX10MM-SMALL_SIZE_U2), V(DRAM_DQS0_P_F3_96_FPGA_DD3_14MMX10MM-SMALL_SIZE_U2), V(DRAM_DQS0_N_G3_96_FPGA_DD3_14MMX10MM-SMALL_SIZE_U2) vs Time on Transient1 : Transient1
  Waveforms at TDR Probes: O(ADRAM_D0_AD2_PBGA624_U1:zl), O(ADRAM_D1_AE2_PBGA624_U1:zl), O(ADRAM_D2_AC4_PBGA624_U1:zl), O(ADRAM_D3_AA5_PBGA624_U1:zl), O(ADRAM_D4_AC1_PBGA624_U1:zl), O(ADRAM_D5_AD1_PBGA624_U1:zl), O(ADRAM_D6_AB4_PBGA624_U1:zl), O(ADRAM_D7_AE4_PBGA624_U1:zl), O(ADRAM_DQS0_P_AE3_PBGA624_U1:zdiff) vs Time on Transient1 : Transient1
