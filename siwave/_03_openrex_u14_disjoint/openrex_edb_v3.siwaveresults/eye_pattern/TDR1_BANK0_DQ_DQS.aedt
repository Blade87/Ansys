# Ansys Electronics Desktop project, version 2022.2

design openrex_edb_v3_TDR1 (Circuit)
options: SParamCircuitDef IntegrationMethod=FFT
components:
  U100 = openrex_edb_v3(Net(DRAM_D0_AD2_PBGA624_U1_ref)=0 Net(DRAM_D0_E3_96_FPGA_DD3_14MMX10MM-SMALL_SIZE_U2_ref)=0 Net(DRAM_D1_AE2_PBGA624_U1_ref)=0 Net(DRAM_D1_H3_96_FPGA_DD3_14MMX10MM-SMALL_SIZE_U2_ref)=0 Net(DRAM_D2_AC4_PBGA624_U1_ref)=0 Net(DRAM_D2_H7_96_FPGA_DD3_14MMX10MM-SMALL_SIZE_U2_ref)=0 Net(DRAM_D3_AA5_PBGA624_U1_ref)=0 Net(DRAM_D3_F8_96_FPGA_DD3_14MMX10MM-SMALL_SIZE_U2_ref)=0 Net(DRAM_D4_AC1_PBGA624_U1_ref)=0 Net(DRAM_D4_F2_96_FPGA_DD3_14MMX10MM-SMALL_SIZE_U2_ref)=0 Net(DRAM_D5_AD1_PBGA624_U1_ref)=0 Net(DRAM_D5_G2_96_FPGA_DD3_14MMX10MM-SMALL_SIZE_U2_ref)=0 Net(DRAM_D6_AB4_PBGA624_U1_ref)=0 Net(DRAM_D6_F7_96_FPGA_DD3_14MMX10MM-SMALL_SIZE_U2_ref)=0 Net(DRAM_D7_AE4_PBGA624_U1_ref)=0 Net(DRAM_D7_H8_96_FPGA_DD3_14MMX10MM-SMALL_SIZE_U2_ref)=0 Net(DRAM_DQS0_N_AD3_PBGA624_U1_ref)=0 Net(DRAM_DQS0_N_G3_96_FPGA_DD3_14MMX10MM-SMALL_SIZE_U2_ref)=0 Net(DRAM_DQS0_P_AE3_PBGA624_U1_ref)=0 Net(DRAM_DQS0_P_F3_96_FPGA_DD3_14MMX10MM-SMALL_SIZE_U2_ref)=0)
  R1 = RES_(R=50ohm)
  R2 = RES_(R=50ohm)
  R3 = RES_(R=50ohm)
  R4 = RES_(R=50ohm)
  R5 = RES_(R=50ohm)
  R6 = RES_(R=50ohm)
  R7 = RES_(R=50ohm)
  R8 = RES_(R=50ohm)
  R9 = RES_(R=100ohm)
  A102 = EYESOURCE(trise=200ps tfall=200ps)
  A105 = EYEPROBE(source_name=AEYESOURCE102 Name=EYE_D5)
  A1 = EYESOURCE(trise=200ps tfall=200ps)
  A2 = EYESOURCE(trise=200ps tfall=200ps)
  A3 = EYESOURCE(trise=200ps tfall=200ps)
  A4 = EYESOURCE(trise=200ps tfall=200ps)
  A5 = EYESOURCE(trise=200ps tfall=200ps)
  A6 = EYESOURCE(trise=200ps tfall=200ps)
  A7 = EYESOURCE(trise=200ps tfall=200ps)
  A118 = EYESOURCE_DIFF(vlow=0V trise=200ps tfall=200ps)
  A8 = EYEPROBE(source_name=AEYESOURCE102 Name=EYE_D0)
  A9 = EYEPROBE(source_name=AEYESOURCE102 Name=EYE_D6)
  A10 = EYEPROBE(source_name=AEYESOURCE102 Name=EYE_D1)
  A11 = EYEPROBE(source_name=AEYESOURCE102 Name=EYE_D7)
  A12 = EYEPROBE(source_name=AEYESOURCE102 Name=EYE_D2)
  A13 = EYEPROBE(source_name=AEYESOURCE102 Name=EYE_D3)
  A14 = EYEPROBE(source_name=AEYESOURCE102 Name=EYE_D4)
  A128 = EYEPROBE_DIFF(source_name=AEYESOURCE112 Name=EYE_DQS0)
nets:
  0: R5.1, R1.1, R2.1, R3.1, R6.1, R4.1, R7.1, R8.1
  DRAM_D0_AD2_PBGA624_U1: U100.DRAM_D0_AD2_PBGA624_U1, A1.0
  DRAM_D0_E3_96_FPGA_DD3_14MMX10MM-SMALL_SIZE_U2: U100.DRAM_D0_E3_96_FPGA_DD3_14MMX10MM-SMALL_SIZE_U2, R1.0, A8.0
  DRAM_D1_AE2_PBGA624_U1: A3.0, U100.DRAM_D1_AE2_PBGA624_U1
  DRAM_D1_H3_96_FPGA_DD3_14MMX10MM-SMALL_SIZE_U2: U100.DRAM_D1_H3_96_FPGA_DD3_14MMX10MM-SMALL_SIZE_U2, R2.0, A10.0
  DRAM_D2_AC4_PBGA624_U1: U100.DRAM_D2_AC4_PBGA624_U1, A5.0
  DRAM_D2_H7_96_FPGA_DD3_14MMX10MM-SMALL_SIZE_U2: U100.DRAM_D2_H7_96_FPGA_DD3_14MMX10MM-SMALL_SIZE_U2, R3.0, A12.0
  DRAM_D3_AA5_PBGA624_U1: U100.DRAM_D3_AA5_PBGA624_U1, A7.0
  DRAM_D3_F8_96_FPGA_DD3_14MMX10MM-SMALL_SIZE_U2: U100.DRAM_D3_F8_96_FPGA_DD3_14MMX10MM-SMALL_SIZE_U2, R4.0, A13.0
  DRAM_D4_AC1_PBGA624_U1: U100.DRAM_D4_AC1_PBGA624_U1, A6.0
  DRAM_D4_F2_96_FPGA_DD3_14MMX10MM-SMALL_SIZE_U2: U100.DRAM_D4_F2_96_FPGA_DD3_14MMX10MM-SMALL_SIZE_U2, R5.0, A14.0
  DRAM_D5_AD1_PBGA624_U1: U100.DRAM_D5_AD1_PBGA624_U1, A102.0
  DRAM_D5_G2_96_FPGA_DD3_14MMX10MM-SMALL_SIZE_U2: U100.DRAM_D5_G2_96_FPGA_DD3_14MMX10MM-SMALL_SIZE_U2, A105.0, R6.0
  DRAM_D6_AB4_PBGA624_U1: A2.0, U100.DRAM_D6_AB4_PBGA624_U1
  DRAM_D6_F7_96_FPGA_DD3_14MMX10MM-SMALL_SIZE_U2: U100.DRAM_D6_F7_96_FPGA_DD3_14MMX10MM-SMALL_SIZE_U2, R7.0, A9.0
  DRAM_D7_AE4_PBGA624_U1: U100.DRAM_D7_AE4_PBGA624_U1, A4.0
  DRAM_D7_H8_96_FPGA_DD3_14MMX10MM-SMALL_SIZE_U2: U100.DRAM_D7_H8_96_FPGA_DD3_14MMX10MM-SMALL_SIZE_U2, R8.0, A11.0
  DRAM_DQS0_N_AD3_PBGA624_U1: U100.DRAM_DQS0_N_AD3_PBGA624_U1, A118.1
  DRAM_DQS0_N_G3_96_FPGA_DD3_14MMX10MM-SMALL_SIZE_U2: U100.DRAM_DQS0_N_G3_96_FPGA_DD3_14MMX10MM-SMALL_SIZE_U2, R9.0, A128.1
  DRAM_DQS0_P_AE3_PBGA624_U1: U100.DRAM_DQS0_P_AE3_PBGA624_U1, A118.0
  DRAM_DQS0_P_F3_96_FPGA_DD3_14MMX10MM-SMALL_SIZE_U2: U100.DRAM_DQS0_P_F3_96_FPGA_DD3_14MMX10MM-SMALL_SIZE_U2, R9.1, A128.0
setups:
  Transient1: TransientData(1e-10, 5e-09) TransientNoiseData(false, "", "", 0, 1, 0, false, 1) TransientOtherData(default)
  VerifEyeAnalysis: VerifEyeAnalysis(false, 1e-9, false, 0, "", true)
  QuickEyeAnalysis: QuickEyeAnalysis(false, 1e-9, false, 0, "", true)
reports:
  Voltage Waveform at Probe/Termination Nodes: V(DRAM_D0_AD2_PBGA624_U1), V(DRAM_D1_AE2_PBGA624_U1), V(DRAM_D2_AC4_PBGA624_U1), V(DRAM_D3_AA5_PBGA624_U1), V(DRAM_D4_AC1_PBGA624_U1), V(DRAM_D5_AD1_PBGA624_U1), V(DRAM_D6_AB4_PBGA624_U1), V(DRAM_D7_AE4_PBGA624_U1), V(DRAM_DQS0_P_AE3_PBGA624_U1), V(DRAM_DQS0_N_AD3_PBGA624_U1), V(DRAM_D0_E3_96_FPGA_DD3_14MMX10MM-SMALL_SIZE_U2), V(DRAM_D1_H3_96_FPGA_DD3_14MMX10MM-SMALL_SIZE_U2), V(DRAM_D2_H7_96_FPGA_DD3_14MMX10MM-SMALL_SIZE_U2), V(DRAM_D3_F8_96_FPGA_DD3_14MMX10MM-SMALL_SIZE_U2), V(DRAM_D4_F2_96_FPGA_DD3_14MMX10MM-SMALL_SIZE_U2), V(DRAM_D5_G2_96_FPGA_DD3_14MMX10MM-SMALL_SIZE_U2), V(DRAM_D6_F7_96_FPGA_DD3_14MMX10MM-SMALL_SIZE_U2), V(DRAM_D7_H8_96_FPGA_DD3_14MMX10MM-SMALL_SIZE_U2), V(DRAM_DQS0_P_F3_96_FPGA_DD3_14MMX10MM-SMALL_SIZE_U2), V(DRAM_DQS0_N_G3_96_FPGA_DD3_14MMX10MM-SMALL_SIZE_U2) vs Time on Transient1 : Transient1
  Waveforms at TDR Probes: O(ADRAM_D0_AD2_PBGA624_U1:zl), O(ADRAM_D1_AE2_PBGA624_U1:zl), O(ADRAM_D2_AC4_PBGA624_U1:zl), O(ADRAM_D3_AA5_PBGA624_U1:zl), O(ADRAM_D4_AC1_PBGA624_U1:zl), O(ADRAM_D5_AD1_PBGA624_U1:zl), O(ADRAM_D6_AB4_PBGA624_U1:zl), O(ADRAM_D7_AE4_PBGA624_U1:zl), O(ADRAM_DQS0_P_AE3_PBGA624_U1:zdiff) vs Time on Transient1 : Transient1
  QuickEye Voltage Plot 1: AEYEPROBE(EYE_D5) vs Time on QuickEyeAnalysis : QuickEyeAnalysis
  QuickEye Voltage Plot 2: AEYEPROBE(EYE_DQS0) vs Time on QuickEyeAnalysis : QuickEyeAnalysis
