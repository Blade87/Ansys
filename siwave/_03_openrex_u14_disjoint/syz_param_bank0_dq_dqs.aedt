# Ansys Electronics Desktop project, version 2022.2
project variables:
  $se_trace_width = 0.12mm
  $layer_thickness = 0.018mm
  $pad_diameter = 0.4mm
materials:
  copper: permeability=0.999991 conductivity=58000000
  FR4_epoxy: permittivity=4.4 dielectric_loss_tangent=0.02
  pec: permeability=1 conductivity=1e+30
  solder: permeability=1 conductivity=7000000
  Solder Resist: permittivity=4.1 dielectric_loss_tangent=0.016
  VT-47: permittivity=4.12 dielectric_loss_tangent=0.014
  VT47-1080: permittivity=3.95 dielectric_loss_tangent=0.016
  VT47-2113: permittivity=4.06 dielectric_loss_tangent=0.016

design openrex_edb_v3 (HFSS 3D Layout)
nets:
  DRAM_D0: port DRAM_D0_AD2_PBGA624_U1, port DRAM_D0_E3_96_FPGA_DD3_14MMX10MM-SMALL_SIZE_U2
  DRAM_D1: port DRAM_D1_AE2_PBGA624_U1, port DRAM_D1_H3_96_FPGA_DD3_14MMX10MM-SMALL_SIZE_U2
  DRAM_D2: port DRAM_D2_AC4_PBGA624_U1, port DRAM_D2_H7_96_FPGA_DD3_14MMX10MM-SMALL_SIZE_U2
  DRAM_D3: port DRAM_D3_AA5_PBGA624_U1, port DRAM_D3_F8_96_FPGA_DD3_14MMX10MM-SMALL_SIZE_U2
  DRAM_D4: port DRAM_D4_AC1_PBGA624_U1, port DRAM_D4_F2_96_FPGA_DD3_14MMX10MM-SMALL_SIZE_U2
  DRAM_D5: port DRAM_D5_AD1_PBGA624_U1, port DRAM_D5_G2_96_FPGA_DD3_14MMX10MM-SMALL_SIZE_U2
  DRAM_D6: port DRAM_D6_AB4_PBGA624_U1, port DRAM_D6_F7_96_FPGA_DD3_14MMX10MM-SMALL_SIZE_U2
  DRAM_D7: port DRAM_D7_AE4_PBGA624_U1, port DRAM_D7_H8_96_FPGA_DD3_14MMX10MM-SMALL_SIZE_U2
  DRAM_DQS0_N: port DRAM_DQS0_N_AD3_PBGA624_U1, port DRAM_DQS0_N_G3_96_FPGA_DD3_14MMX10MM-SMALL_SIZE_U2
  DRAM_DQS0_P: port DRAM_DQS0_P_AE3_PBGA624_U1, port DRAM_DQS0_P_F3_96_FPGA_DD3_14MMX10MM-SMALL_SIZE_U2
ports:
  DRAM_D0_AD2_PBGA624_U1: Properties{Impedance=50ohm Magnitude=0V Phase=0deg Renormalize_Impedence=50ohm Deembed_Distance=0mm Type=Circuit HFSS_Type=Circuit Orientation=Horizontal Layer_Alignment=Upper Horizontal_Extent_Factor=5 Vertical_Extent_Factor=3 PEC_Launch_Width=0mm Reference_Net=GND} Type="Pad Port" Pin=DRAM_D0_AD2_PBGA624_U1 CircuitPort
  DRAM_D0_E3_96_FPGA_DD3_14MMX10MM-SMALL_SIZE_U2: Properties{Impedance=50ohm Magnitude=0V Phase=0deg Renormalize_Impedence=50ohm Deembed_Distance=0mm Type=Circuit HFSS_Type=Circuit Orientation=Horizontal Layer_Alignment=Upper Horizontal_Extent_Factor=5 Vertical_Extent_Factor=3 PEC_Launch_Width=0mm Reference_Net=GND} Type="Pad Port" Pin=DRAM_D0_E3_96_FPGA_DD3_14MMX10MM-SMALL_SIZE_U2 CircuitPort
  DRAM_D1_AE2_PBGA624_U1: Properties{Impedance=50ohm Magnitude=0V Phase=0deg Renormalize_Impedence=50ohm Deembed_Distance=0mm Type=Circuit HFSS_Type=Circuit Orientation=Horizontal Layer_Alignment=Upper Horizontal_Extent_Factor=5 Vertical_Extent_Factor=3 PEC_Launch_Width=0mm Reference_Net=GND} Type="Pad Port" Pin=DRAM_D1_AE2_PBGA624_U1 CircuitPort
  DRAM_D1_H3_96_FPGA_DD3_14MMX10MM-SMALL_SIZE_U2: Properties{Impedance=50ohm Magnitude=0V Phase=0deg Renormalize_Impedence=50ohm Deembed_Distance=0mm Type=Circuit HFSS_Type=Circuit Orientation=Horizontal Layer_Alignment=Upper Horizontal_Extent_Factor=5 Vertical_Extent_Factor=3 PEC_Launch_Width=0mm Reference_Net=GND} Type="Pad Port" Pin=DRAM_D1_H3_96_FPGA_DD3_14MMX10MM-SMALL_SIZE_U2 CircuitPort
  DRAM_D2_AC4_PBGA624_U1: Properties{Impedance=50ohm Magnitude=0V Phase=0deg Renormalize_Impedence=50ohm Deembed_Distance=0mm Type=Circuit HFSS_Type=Circuit Orientation=Horizontal Layer_Alignment=Upper Horizontal_Extent_Factor=5 Vertical_Extent_Factor=3 PEC_Launch_Width=0mm Reference_Net=GND} Type="Pad Port" Pin=DRAM_D2_AC4_PBGA624_U1 CircuitPort
  DRAM_D2_H7_96_FPGA_DD3_14MMX10MM-SMALL_SIZE_U2: Properties{Impedance=50ohm Magnitude=0V Phase=0deg Renormalize_Impedence=50ohm Deembed_Distance=0mm Type=Circuit HFSS_Type=Circuit Orientation=Horizontal Layer_Alignment=Upper Horizontal_Extent_Factor=5 Vertical_Extent_Factor=3 PEC_Launch_Width=0mm Reference_Net=GND} Type="Pad Port" Pin=DRAM_D2_H7_96_FPGA_DD3_14MMX10MM-SMALL_SIZE_U2 CircuitPort
  DRAM_D3_AA5_PBGA624_U1: Properties{Impedance=50ohm Magnitude=0V Phase=0deg Renormalize_Impedence=50ohm Deembed_Distance=0mm Type=Circuit HFSS_Type=Circuit Orientation=Horizontal Layer_Alignment=Upper Horizontal_Extent_Factor=5 Vertical_Extent_Factor=3 PEC_Launch_Width=0mm Reference_Net=GND} Type="Pad Port" Pin=DRAM_D3_AA5_PBGA624_U1 CircuitPort
  DRAM_D3_F8_96_FPGA_DD3_14MMX10MM-SMALL_SIZE_U2: Properties{Impedance=50ohm Magnitude=0V Phase=0deg Renormalize_Impedence=50ohm Deembed_Distance=0mm Type=Circuit HFSS_Type=Circuit Orientation=Horizontal Layer_Alignment=Upper Horizontal_Extent_Factor=5 Vertical_Extent_Factor=3 PEC_Launch_Width=0mm Reference_Net=GND} Type="Pad Port" Pin=DRAM_D3_F8_96_FPGA_DD3_14MMX10MM-SMALL_SIZE_U2 CircuitPort
  DRAM_D4_AC1_PBGA624_U1: Properties{Impedance=50ohm Magnitude=0V Phase=0deg Renormalize_Impedence=50ohm Deembed_Distance=0mm Type=Circuit HFSS_Type=Circuit Orientation=Horizontal Layer_Alignment=Upper Horizontal_Extent_Factor=5 Vertical_Extent_Factor=3 PEC_Launch_Width=0mm Reference_Net=GND} Type="Pad Port" Pin=DRAM_D4_AC1_PBGA624_U1 CircuitPort
  DRAM_D4_F2_96_FPGA_DD3_14MMX10MM-SMALL_SIZE_U2: Properties{Impedance=50ohm Magnitude=0V Phase=0deg Renormalize_Impedence=50ohm Deembed_Distance=0mm Type=Circuit HFSS_Type=Circuit Orientation=Horizontal Layer_Alignment=Upper Horizontal_Extent_Factor=5 Vertical_Extent_Factor=3 PEC_Launch_Width=0mm Reference_Net=GND} Type="Pad Port" Pin=DRAM_D4_F2_96_FPGA_DD3_14MMX10MM-SMALL_SIZE_U2 CircuitPort
  DRAM_D5_AD1_PBGA624_U1: Properties{Impedance=50ohm Magnitude=0V Phase=0deg Renormalize_Impedence=50ohm Deembed_Distance=0mm Type=Circuit HFSS_Type=Circuit Orientation=Horizontal Layer_Alignment=Upper Horizontal_Extent_Factor=5 Vertical_Extent_Factor=3 PEC_Launch_Width=0mm Reference_Net=GND} Type="Pad Port" Pin=DRAM_D5_AD1_PBGA624_U1 CircuitPort
  DRAM_D5_G2_96_FPGA_DD3_14MMX10MM-SMALL_SIZE_U2: Properties{Impedance=50ohm Magnitude=0V Phase=0deg Renormalize_Impedence=50ohm Deembed_Distance=0mm Type=Circuit HFSS_Type=Circuit Orientation=Horizontal Layer_Alignment=Upper Horizontal_Extent_Factor=5 Vertical_Extent_Factor=3 PEC_Launch_Width=0mm Reference_Net=GND} Type="Pad Port" Pin=DRAM_D5_G2_96_FPGA_DD3_14MMX10MM-SMALL_SIZE_U2 CircuitPort
  DRAM_D6_AB4_PBGA624_U1: Properties{Impedance=50ohm Magnitude=0V Phase=0deg Renormalize_Impedence=50ohm Deembed_Distance=0mm Type=Circuit HFSS_Type=Circuit Orientation=Horizontal Layer_Alignment=Upper Horizontal_Extent_Factor=5 Vertical_Extent_Factor=3 PEC_Launch_Width=0mm Reference_Net=GND} Type="Pad Port" Pin=DRAM_D6_AB4_PBGA624_U1 CircuitPort
  DRAM_D6_F7_96_FPGA_DD3_14MMX10MM-SMALL_SIZE_U2: Properties{Impedance=50ohm Magnitude=0V Phase=0deg Renormalize_Impedence=50ohm Deembed_Distance=0mm Type=Circuit HFSS_Type=Circuit Orientation=Horizontal Layer_Alignment=Upper Horizontal_Extent_Factor=5 Vertical_Extent_Factor=3 PEC_Launch_Width=0mm Reference_Net=GND} Type="Pad Port" Pin=DRAM_D6_F7_96_FPGA_DD3_14MMX10MM-SMALL_SIZE_U2 CircuitPort
  DRAM_D7_AE4_PBGA624_U1: Properties{Impedance=50ohm Magnitude=0V Phase=0deg Renormalize_Impedence=50ohm Deembed_Distance=0mm Type=Circuit HFSS_Type=Circuit Orientation=Horizontal Layer_Alignment=Upper Horizontal_Extent_Factor=5 Vertical_Extent_Factor=3 PEC_Launch_Width=0mm Reference_Net=GND} Type="Pad Port" Pin=DRAM_D7_AE4_PBGA624_U1 CircuitPort
  DRAM_D7_H8_96_FPGA_DD3_14MMX10MM-SMALL_SIZE_U2: Properties{Impedance=50ohm Magnitude=0V Phase=0deg Renormalize_Impedence=50ohm Deembed_Distance=0mm Type=Circuit HFSS_Type=Circuit Orientation=Horizontal Layer_Alignment=Upper Horizontal_Extent_Factor=5 Vertical_Extent_Factor=3 PEC_Launch_Width=0mm Reference_Net=GND} Type="Pad Port" Pin=DRAM_D7_H8_96_FPGA_DD3_14MMX10MM-SMALL_SIZE_U2 CircuitPort
  DRAM_DQS0_N_AD3_PBGA624_U1: Properties{Impedance=50ohm Magnitude=0V Phase=0deg Renormalize_Impedence=50ohm Deembed_Distance=0mm Type=Circuit HFSS_Type=Circuit Orientation=Horizontal Layer_Alignment=Upper Horizontal_Extent_Factor=5 Vertical_Extent_Factor=3 PEC_Launch_Width=0mm Reference_Net=GND} Type="Pad Port" Pin=DRAM_DQS0_N_AD3_PBGA624_U1 CircuitPort
  DRAM_DQS0_N_G3_96_FPGA_DD3_14MMX10MM-SMALL_SIZE_U2: Properties{Impedance=50ohm Magnitude=0V Phase=0deg Renormalize_Impedence=50ohm Deembed_Distance=0mm Type=Circuit HFSS_Type=Circuit Orientation=Horizontal Layer_Alignment=Upper Horizontal_Extent_Factor=5 Vertical_Extent_Factor=3 PEC_Launch_Width=0mm Reference_Net=GND} Type="Pad Port" Pin=DRAM_DQS0_N_G3_96_FPGA_DD3_14MMX10MM-SMALL_SIZE_U2 CircuitPort
  DRAM_DQS0_P_AE3_PBGA624_U1: Properties{Impedance=50ohm Magnitude=0V Phase=0deg Renormalize_Impedence=50ohm Deembed_Distance=0mm Type=Circuit HFSS_Type=Circuit Orientation=Horizontal Layer_Alignment=Upper Horizontal_Extent_Factor=5 Vertical_Extent_Factor=3 PEC_Launch_Width=0mm Reference_Net=GND} Type="Pad Port" Pin=DRAM_DQS0_P_AE3_PBGA624_U1 CircuitPort
  DRAM_DQS0_P_F3_96_FPGA_DD3_14MMX10MM-SMALL_SIZE_U2: Properties{Impedance=50ohm Magnitude=0V Phase=0deg Renormalize_Impedence=50ohm Deembed_Distance=0mm Type=Circuit HFSS_Type=Circuit Orientation=Horizontal Layer_Alignment=Upper Horizontal_Extent_Factor=5 Vertical_Extent_Factor=3 PEC_Launch_Width=0mm Reference_Net=GND} Type="Pad Port" Pin=DRAM_DQS0_P_F3_96_FPGA_DD3_14MMX10MM-SMALL_SIZE_U2 CircuitPort
setups:
  DC IR Sim 1: SolveSetupType=SIwaveDCIR
  SIwave SYZ 1: SolveSetupType=SIwave
    sweep SYZ_BANK0_DQ_DQS: 0Hz DEC 1Hz 10MHz 50 LINC 10MHz 10GHz 500;
    sweep SYZ_PARAM_BANK0_DQ_DQS: LINC 0Hz 10GHz 101;
optimetrics:
  ParametricSetup1: Parametric Sim._Setups=[DC IR Sim 1, SIwave SYZ 1]
    sweep $se_trace_width: LINC 0.06mm 0.18mm 3
    sweep $layer_thickness: LINC 0.009mm 0.027mm 3
reports:
  S Parameter Plot 1: dB(S(DRAM_D0_AD2_PBGA624_U1,DRAM_D0_AD2_PBGA624_U1)) vs Freq on SIwave SYZ 1 : SYZ_PARAM_BANK0_DQ_DQS [$se_trace_width=0.06mm,0.12mm,0.18mm $layer_thickness=0.009mm,0.018mm,0.027mm $pad_diameter=all]
